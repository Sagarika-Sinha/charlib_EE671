* NGSPICE file created from dfxtp.ext - technology: sky130A
.subckt dfxtp D CLK Q VDD VSS
X0 a_688_56# a_355_30# a_385_56# VDD sky130_fd_pr__pfet_01v8 ad=0.4368 pd=2.005 as=0.4368 ps=2.005 w=0.64 l=0.15
X1 Q a_2143_30# VDD VDD sky130_fd_pr__pfet_01v8 ad=0.432 pd=3.34 as=0.45771 ps=3.26269 w=1.35 l=0.15
X2 a_385_56# a_355_30# a_284_56# VSS sky130_fd_pr__nfet_01v8 ad=0.28665 pd=1.785 as=0.07455 ps=0.775 w=0.42 l=0.15
X3 VSS a_1567_56# a_2143_30# VSS sky130_fd_pr__nfet_01v8 ad=0.13099 pd=1.25375 as=0.1344 ps=1.48 w=0.42 l=0.15
X4 a_1870_56# a_355_30# a_1567_56# VSS sky130_fd_pr__nfet_01v8 ad=0.28665 pd=1.785 as=0.28665 ps=1.785 w=0.42 l=0.15
X5 a_688_56# a_355_280# a_385_56# VSS sky130_fd_pr__nfet_01v8 ad=0.28665 pd=1.785 as=0.28665 ps=1.785 w=0.42 l=0.15
X6 a_355_280# a_355_30# VSS VSS sky130_fd_pr__nfet_01v8 ad=0.1344 pd=1.48 as=0.13099 ps=1.25375 w=0.42 l=0.15
X7 a_284_56# D VSS VSS sky130_fd_pr__nfet_01v8 ad=0.07455 pd=0.775 as=0.13099 ps=1.25375 w=0.42 l=0.15
X8 a_1870_56# a_355_280# a_1567_56# VDD sky130_fd_pr__pfet_01v8 ad=0.4368 pd=2.005 as=0.4368 ps=2.005 w=0.64 l=0.15
X9 a_385_56# a_355_280# a_284_56# VDD sky130_fd_pr__pfet_01v8 ad=0.4368 pd=2.005 as=0.1136 ps=0.995 w=0.64 l=0.15
X10 VDD a_1567_56# a_2143_30# VDD sky130_fd_pr__pfet_01v8 ad=0.21699 pd=1.54676 as=0.2048 ps=1.92 w=0.64 l=0.15
X11 a_1567_56# a_355_280# a_961_30# VSS sky130_fd_pr__nfet_01v8 ad=0.28665 pd=1.785 as=0.07455 ps=0.775 w=0.42 l=0.15
X12 Q a_2143_30# VSS VSS sky130_fd_pr__nfet_01v8 ad=0.1344 pd=1.48 as=0.13099 ps=1.25375 w=0.42 l=0.15
X13 VSS a_2143_30# a_1870_56# VSS sky130_fd_pr__nfet_01v8 ad=0.13099 pd=1.25375 as=0.28665 ps=1.785 w=0.42 l=0.15
X14 VSS CLK a_355_30# VSS sky130_fd_pr__nfet_01v8 ad=0.13099 pd=1.25375 as=0.1344 ps=1.48 w=0.42 l=0.15
X15 a_284_56# D VDD VDD sky130_fd_pr__pfet_01v8 ad=0.1136 pd=0.995 as=0.21699 ps=1.54676 w=0.64 l=0.15
X16 VDD a_961_30# a_688_56# VDD sky130_fd_pr__pfet_01v8 ad=0.21699 pd=1.54676 as=0.4368 ps=2.005 w=0.64 l=0.15
X17 VDD a_2143_30# a_1870_56# VDD sky130_fd_pr__pfet_01v8 ad=0.21699 pd=1.54676 as=0.4368 ps=2.005 w=0.64 l=0.15
X18 a_961_30# a_385_56# VSS VSS sky130_fd_pr__nfet_01v8 ad=0.07455 pd=0.775 as=0.13099 ps=1.25375 w=0.42 l=0.15
X19 a_1567_56# a_355_30# a_961_30# VDD sky130_fd_pr__pfet_01v8 ad=0.4368 pd=2.005 as=0.1136 ps=0.995 w=0.64 l=0.15
X20 a_355_280# a_355_30# VDD VDD sky130_fd_pr__pfet_01v8 ad=0.2048 pd=1.92 as=0.21699 ps=1.54676 w=0.64 l=0.15
X21 VSS a_961_30# a_688_56# VSS sky130_fd_pr__nfet_01v8 ad=0.13099 pd=1.25375 as=0.28665 ps=1.785 w=0.42 l=0.15
X22 a_961_30# a_385_56# VDD VDD sky130_fd_pr__pfet_01v8 ad=0.1136 pd=0.995 as=0.21699 ps=1.54676 w=0.64 l=0.15
X23 VDD CLK a_355_30# VDD sky130_fd_pr__pfet_01v8 ad=0.21699 pd=1.54676 as=0.2048 ps=1.92 w=0.64 l=0.15
C0 Q a_1567_56# 0.00562f
C1 a_1567_56# a_355_280# 0.19747f
C2 Q a_355_280# 0
C3 a_355_30# a_1567_56# 0.36121f
C4 a_355_30# Q 0
C5 a_961_30# a_1567_56# 0.06999f
C6 a_2143_30# a_1567_56# 0.57314f
C7 a_2143_30# Q 0.11662f
C8 a_355_30# a_355_280# 2.13928f
C9 a_1567_56# a_385_56# 0.01895f
C10 a_1870_56# a_1567_56# 0.08847f
C11 a_961_30# a_355_280# 0.12658f
C12 VDD a_1567_56# 0.36824f
C13 a_2143_30# a_355_280# 0.09248f
C14 CLK a_1567_56# 0.0035f
C15 VDD Q 0.10314f
C16 a_688_56# a_355_280# 0.09352f
C17 a_355_30# a_961_30# 0.27768f
C18 a_284_56# a_355_280# 0.05668f
C19 a_355_280# a_385_56# 0.18697f
C20 D a_355_280# 0.0335f
C21 a_2143_30# a_355_30# 0.46742f
C22 a_1870_56# a_355_280# 0.04934f
C23 VDD a_355_280# 1.33711f
C24 a_355_30# a_688_56# 0.03603f
C25 a_2143_30# a_961_30# 0.00611f
C26 CLK a_355_280# 0.01332f
C27 a_284_56# a_355_30# 0.03952f
C28 a_355_30# a_385_56# 0.33065f
C29 a_355_30# D 0.03047f
C30 a_1870_56# a_355_30# 0.08183f
C31 a_688_56# a_961_30# 0.0571f
C32 VDD a_355_30# 0.95349f
C33 a_284_56# a_961_30# 0
C34 a_961_30# a_385_56# 0.28898f
C35 D a_961_30# 0.00185f
C36 CLK a_355_30# 0.15778f
C37 a_2143_30# a_385_56# 0.00128f
C38 a_1870_56# a_961_30# 0
C39 a_1870_56# a_2143_30# 0.0485f
C40 VDD a_961_30# 0.38212f
C41 VDD a_2143_30# 0.57995f
C42 a_688_56# a_385_56# 0.09615f
C43 D a_688_56# 0
C44 CLK a_2143_30# 0.01969f
C45 a_284_56# a_385_56# 0.06303f
C46 a_284_56# D 0.04312f
C47 D a_385_56# 0.00133f
C48 a_1870_56# a_385_56# 0
C49 VDD a_688_56# 0.14185f
C50 VDD a_284_56# 0.12423f
C51 VDD a_385_56# 0.36244f
C52 VDD D 0.17546f
C53 VDD a_1870_56# 0.14077f
C54 CLK a_1870_56# 0.00301f
C55 CLK VDD 0.21439f
C56 Q VSS 0.13536f
C57 CLK VSS 0.12479f
C58 D VSS 0.19185f
C59 VDD VSS 5.95176f
C60 a_1870_56# VSS 0.10113f
C61 a_688_56# VSS 0.10159f
C62 a_284_56# VSS 0.11159f
C63 a_1567_56# VSS 0.846f
C64 a_2143_30# VSS 0.78124f
C65 a_385_56# VSS 0.61627f
C66 a_961_30# VSS 0.38764f
C67 a_355_30# VSS 0.76084f
C68 a_355_280# VSS 0.85217f
.ends
